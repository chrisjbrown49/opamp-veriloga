// Verilog-A Modular Macromodel for Operational Amplifiers
// Based on the Qucs-Brinson model by Mike Brinson
// Default parameters are for a typical UA741 operational amplifier.
//
// Copyright (C) 2007, Mike Brinson, mbrin72043@yahoo.co.uk
// Adapted for OpenVAF/ngspice compatibility.
//
// Modifications for floating-supply / floating-ground operation:
//   Mod 1 - RPULL: pull resistors from output to both supply rails provide a
//            DC Jacobian path needed when the supply rails float relative to
//            simulator ground (e.g. battery-powered implantable devices).
//   Mod 2 - Supply stubs changed from ground-referenced (I(vdd) <+ V(vdd)*eps)
//            to a between-rail path (I(vdd,vss) <+ V(vdd,vss)*eps) so the model
//            itself imposes no absolute-ground anchor on the supply rails.
//   Mod 3 - Output stage redesigned as a pair of voltage-controlled conductances
//            from VDD and VSS to the output.  The Thevenin equivalent seen at the
//            output is unchanged (V_th = V(n4), R_th = RO), but drive current now
//            flows through the supply pins rather than through absolute ground.
//            As a side-effect, the if/else current limiter and voltage clamp are
//            replaced with smooth equivalents (smooth_max via sqrt), which also
//            improves DC-sweep convergence in open-loop / comparator configurations.
//
// This is free software; you can redistribute it and/or modify
// it under the terms of the GNU General Public License as published by
// the Free Software Foundation; either version 2, or (at your option)
// any later version.

`include "disciplines.vams"
`include "constants.vams"

module opamp_module(inp, inn, out, vdd, vss);
    inout inp, inn, out, vdd, vss;
    electrical inp, inn, out, vdd, vss;
    electrical n2, n3, n4, n5, n6, n7, n8, n9, n10, n11, n12;

    (* desc="Gain bandwidth product", units="Hz" *)
    parameter real GBP = 1e6 from [1 : inf);

    (* desc="Open loop DC gain", units="dB" *)
    parameter real AOLDC = 106.0 from [0.01 : inf);

    (* desc="Second pole frequency", units="Hz" *)
    parameter real FP2 = 3e6 from [0.01 : inf);

    // Must be > 1 because the output stage uses (RO-1) as the pull resistance
    // with a 1-ohm series sense resistor to give a total Thevenin impedance of RO.
    (* desc="Output resistance", units="Ohm" *)
    parameter real RO = 75 from [2 : inf);

    (* desc="Differential input capacitance", units="F" *)
    parameter real CD = 1e-12 from [1e-20 : inf);

    (* desc="Differential input resistance", units="Ohm" *)
    parameter real RD = 2e6 from [0.01 : inf);

    (* desc="Input offset current", units="A" *)
    parameter real IOFF = 20e-9 from [1e-20 : inf);

    (* desc="Input bias current", units="A" *)
    parameter real IB = 80e-9 from [1e-20 : inf);

    (* desc="Input offset voltage", units="V" *)
    parameter real VOFF = 7e-4 from [0 : inf);

    (* desc="Common-mode rejection ratio at DC", units="dB" *)
    parameter real CMRRDC = 90.0 from [1 : inf);

    (* desc="Common-mode zero corner frequency", units="Hz" *)
    parameter real FCM = 200 from [0.01 : inf);

    (* desc="Positive slew rate", units="V/s" *)
    parameter real PSRT = 5e5 from [1 : inf);

    (* desc="Negative slew rate", units="V/s" *)
    parameter real NSRT = 5e5 from [1 : inf);

    (* desc="Maximum DC output current", units="A" *)
    parameter real ILMAX = 35e-3 from [1e-9 : inf);

    (* desc="Current limit scaling factor" *)
    parameter real CSCALE = 50 from [0 : inf);

    // Mod 1: pull resistors from output to each supply rail.
    // Provide a DC Jacobian path for floating-supply simulations and model
    // real output-stage leakage to both rails.  At 1 MOhm the quiescent
    // current is ~1.5 uA per rail for a 3 V supply, negligible for most loads.
    (* desc="Output pull resistor to each supply rail", units="Ohm" *)
    parameter real RPULL = 1e6 from [1e3 : inf);

    real RP1, CP1, RP2, CP2;
    real Rdiff, Voffset;
    real CMRR0, CMgain, CCM;
    real Slewratepositive, Slewratenegative;
    real MTWOPI;
    // Mod 3 working variables
    real Vcs, smooth_hi, smooth_lo;
    real Vspan, g_up, g_dn;
    real Vclamp_hi, Vclamp_lo;

    analog begin
        MTWOPI = 6.28318530717958647693;

        Voffset = VOFF / 2;
        Rdiff = RD / 2;
        CMRR0 = pow(10, CMRRDC / 20);
        CMgain = 1e6 / CMRR0;
        CCM = 1.0 / (MTWOPI * 1e6 * FCM);
        RP1 = pow(10, AOLDC / 20);
        CP1 = 1 / (MTWOPI * GBP);
        RP2 = 1;
        CP2 = 1 / (MTWOPI * FP2);
        Slewratepositive = PSRT / (MTWOPI * GBP);
        Slewratenegative = NSRT / (MTWOPI * GBP);

        // Mod 2: quiescent supply path flows between rails, not to ground.
        // The model no longer imposes any absolute-ground anchor on VDD or VSS.
        I(vdd, vss) <+ V(vdd, vss) * 1e-12;

        // Input voltage offset
        I(inp, n7) <+ V(inp, n7);
        I(inp, n7) <+ Voffset;

        I(inn, n9) <+ V(inn, n9);
        I(inn, n9) <+ -Voffset;

        // Input bias currents
        I(n7) <+ IB;
        I(n9) <+ IB;

        // Input current offset
        I(n7, n9) <+ IOFF / 2;

        // Input differential resistance and capacitance
        I(n7, n8) <+ V(n7, n8) / Rdiff;
        I(n9, n8) <+ V(n9, n8) / Rdiff;
        I(n7, n9) <+ ddt(CD * V(n7, n9));

        // Common-mode stage
        I(n6) <+ -CMgain * V(n8);
        I(n6) <+ V(n6);
        I(n6, n10) <+ V(n6, n10) / 1e6;
        I(n6, n10) <+ ddt(CCM * V(n6, n10));
        I(n10) <+ V(n10);

        // Differential and common-mode signal adder
        I(n11) <+ -V(n10);
        I(n11) <+ -V(n7, n9);
        I(n11) <+ V(n11);

        // Slew rate limiting stage
        if (V(n11) > Slewratepositive)
            I(n12) <+ -Slewratepositive;
        else if (V(n11) < -Slewratenegative)
            I(n12) <+ Slewratenegative;
        else
            I(n12) <+ -V(n11);
        I(n12) <+ V(n12);

        // First pole (gain stage)
        I(n3) <+ -V(n12);
        I(n3) <+ V(n3) / RP1;
        I(n3) <+ ddt(CP1 * V(n3));

        // Second pole
        I(n5) <+ -V(n3);
        I(n5) <+ V(n5) / RP2;
        I(n5) <+ ddt(CP2 * V(n5));

        // Mod 3a: smooth current limiter.
        // Replaces the original if/else block with continuous smooth_max
        // approximations: smooth_max(0, x) = (x + sqrt(x^2 + eps)) / 2.
        //
        // smooth_hi activates when the output sources more than ILMAX (Vcs > +ILMAX).
        // smooth_lo activates when the output sinks more than ILMAX (Vcs < -ILMAX).
        // Together they reproduce the original fold-back behaviour continuously,
        // which also improves Newton-Raphson convergence in DC analyses.
        //
        // Mathematical equivalence to the original piecewise block:
        //   Vcs > +ILMAX: added term = CSCALE*V(n5)*(Vcs-ILMAX)          [same]
        //   Vcs < -ILMAX: added term = CSCALE*V(n5)*(-Vcs-ILMAX)         [same]
        //   |Vcs| <= ILMAX: smooth_hi = smooth_lo = 0, no added term      [same]
        Vcs = V(n2, out);
        smooth_hi = 0.5 * ((Vcs - ILMAX) + sqrt((Vcs - ILMAX) * (Vcs - ILMAX) + 1e-12));
        smooth_lo = 0.5 * ((-Vcs - ILMAX) + sqrt((-Vcs - ILMAX) * (-Vcs - ILMAX) + 1e-12));

        I(n4) <+ -V(n5);
        I(n4) <+ CSCALE * V(n5) * (smooth_hi + smooth_lo);
        I(n4) <+ V(n4);

        // Mod 3b: supply-referenced output stage.
        // Replaces the original absolute-ground resistive chain:
        //     n4 --(RO-1 ohm)--> n2 --(1 ohm)--> out
        // with a pair of voltage-controlled conductances from VDD and VSS.
        //
        // The Thevenin equivalent at the output is unchanged:
        //     V_th = V(n4),  R_th = RO
        // Proof: I_out = g_up*(VDD-V_out) - g_dn*(V_out-VSS)
        //             = [V(n4)*(VDD-VSS)] / [(RO-1)*Vspan]  -  V_out/(RO-1)
        //             = (V(n4) - V_out) / RO    (after adding the 1-ohm sense)
        //
        // Crucially, the drive current now flows through VDD and VSS rather than
        // through absolute simulator ground, so the supply rail potentials respond
        // correctly when they are floating and the output is held by feedback.
        //
        // Vspan floor: smooth_max(0, Vspan) prevents division by zero if VDD~=VSS.
        // Conductance floors: smooth_max(0, g) prevents negative conductance when
        //   V(n4) is driven outside [VSS, VDD] by the current-limiting fold-back.
        Vspan = V(vdd) - V(vss);
        Vspan = 0.5 * (Vspan + sqrt(Vspan * Vspan + 1e-6));

        g_up = (V(n4) - V(vss)) / ((RO - 1) * Vspan);
        g_dn = (V(vdd) - V(n4)) / ((RO - 1) * Vspan);
        g_up = 0.5 * (g_up + sqrt(g_up * g_up + 1e-12));
        g_dn = 0.5 * (g_dn + sqrt(g_dn * g_dn + 1e-12));

        I(vdd, n2) <+ g_up * V(vdd, n2);   // pull-up:   VDD --> n2
        I(n2, vss) <+ g_dn * V(n2, vss);   // pull-down: n2  --> VSS
        I(n2, out) <+ V(n2, out);           // 1-ohm current sense

        // Mod 3c: smooth voltage clamp to supply rails.
        // Replaces the original if/else clamp.  Uses smooth_max(0, x) so the
        // 10-siemens clamping conductance activates gradually rather than
        // switching abruptly, restoring Newton-Raphson convergence in DC sweeps.
        // Current flows through the supply pins (I(out,vdd) and I(vss,out))
        // rather than through absolute ground.
        Vclamp_hi = 0.5 * (V(out, vdd) + sqrt(V(out, vdd) * V(out, vdd) + 1e-6));
        Vclamp_lo = 0.5 * (V(vss, out) + sqrt(V(vss, out) * V(vss, out) + 1e-6));
        I(out, vdd) <+ 10.0 * Vclamp_hi;   // pulls out down when V(out) > V(vdd)
        I(vss, out) <+ 10.0 * Vclamp_lo;   // pulls out up  when V(out) < V(vss)

        // Mod 1: output pull resistors to both supply rails.
        I(out, vdd) <+ V(out, vdd) / RPULL;
        I(out, vss) <+ V(out, vss) / RPULL;
    end
endmodule
