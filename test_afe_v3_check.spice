** Check AFE results - based on test_afe_v3.spice
.control
pre_osdi /home/chris/.xschem/xschem_library/custom/opamp.osdi
.endc

V2 VDD GND 3.0
V3 VREF GND dc 3.0 pwl 0 0 50u 3 100u 0
V4 VB1 GND 1.5
V1 VB2 GND 1.5
XM1 D VREF S S sky130_fd_pr__nfet_01v8 L=0.15 W=1 nf=1 ad=0.29 as=0.29 pd=2.58 ps=2.58 nrd=0.29 nrs=0.29 sa=0 sb=0 sd=0 mult=1 m=1
XM2 S net2 A A sky130_fd_pr__nfet_01v8 L=0.15 W=1 nf=1 ad=0.29 as=0.29 pd=2.58 ps=2.58 nrd=0.29 nrs=0.29 sa=0 sb=0 sd=0 mult=1 m=1
R1 A GND 10k m=1
R3 net2 net1 1k m=1
R2 B Z 10k m=1
R4 B net3 30k m=1
R5 net4 D 10k m=1
R6 C net4 10k m=1
R7 C B 10k m=1
V5 GND VSS 3.0
XU1 VB2 net3 net3 VDD VSS opamp_cell
XU2 S Z Z VDD VSS opamp_cell
XU3 VB1 A net1 VDD VSS opamp_cell
XU5 GND net4 D VDD VSS opamp_cell
XU4 GND B C VDD VSS opamp_cell

.lib /usr/local/share/pdk/sky130B/libs.tech/combined/sky130.lib.spice tt_mm
.GLOBAL VDD
.GLOBAL GND
.option temp = 25
.option method=gear reltol=5e-3 itl4=500 trtol=7

.subckt opamp_cell INP INN OUT VDD VSS
N1 inp inn out vdd vss opamp_model
.ends opamp_cell

.model opamp_model opamp_module

.control
save all
tran 100n 100u
meas tran vref_10u FIND v(vref) AT=10u
meas tran d_10u FIND v(d) AT=10u
meas tran s_10u FIND v(s) AT=10u
meas tran vref_25u FIND v(vref) AT=25u
meas tran d_25u FIND v(d) AT=25u
meas tran s_25u FIND v(s) AT=25u
meas tran vref_50u FIND v(vref) AT=50u
meas tran d_50u FIND v(d) AT=50u
meas tran s_50u FIND v(s) AT=50u
meas tran vref_75u FIND v(vref) AT=75u
meas tran d_75u FIND v(d) AT=75u
meas tran s_75u FIND v(s) AT=75u
quit 0
.endc

.end
